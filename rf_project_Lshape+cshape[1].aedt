# Ansys Electronics Desktop project, version 2023.2
materials:
  vacuum: permittivity=1
  FR4_epoxy: permittivity=4.4 dielectric_loss_tangent=0.02
  air: permittivity=1.0006 permeability=1.0000004

design HFSSDesign1 (HFSS, HFSS Terminal Network, model units mm)
variables:
  L_gnd = 3mm
  W_sub = 19mm
geometry:
  substrate [FR4_epoxy] = box(corner=((-15/2) mm, -W_sub/2, 0mm), size=(15mm, W_sub, 1.6mm))
  ground = rectangle(corner=(7.5 mm - L_gnd, -7.5mm, 0mm), x_size=L_gnd, y_size=15mm)
  Rectangle7 = rectangle(corner=(7.5mm, -1mm, 1.6mm), y_size=2mm, z_size=-1.6mm)
  RadiatingSurface [vacuum] = region(absolute_offset=41.666667mm on all sides)
  patch [vacuum] = imported_body()
boundaries and excitations:
  PerfE1: Perfect E Objects=ground
  PerfE2: Perfect E Objects=patch
  Open1: Radiation Objects=RadiatingSurface
  1: Lumped Port Objects=Rectangle7 LumpedPortType=Modal Modes{Mode1{IntLine{(7.5, 0, 0) -> (7.5, 0, 1.6)} CharImp=Zpi}} Impedance=50ohm
setups:
  Setup1: HfssDriven Frequency=2.4GHz MaxDeltaS=0.02 MaximumPasses=10 MinimumPasses=1 MinimumConvergedPasses=1 PercentRefinement=30 BasisOrder=1 PortAccuracy=2 DrivenSolverType="Direct Solver"
    sweep Sweep: 1.2GHz to 8GHz, 42 points; Type=Discrete SaveFields SaveRadFields
  Setup2: HfssDriven Frequency=3.5GHz MaxDeltaS=0.02 MaximumPasses=10 MinimumPasses=1 MinimumConvergedPasses=1 PercentRefinement=30 BasisOrder=1 PortAccuracy=2 DrivenSolverType="Direct Solver"
    sweep Sweep: 1.2GHz to 12GHz, 100 points; Type=Discrete SaveFields SaveRadFields
  Setup3: HfssDriven Frequency=5.5GHz MaxDeltaS=0.02 MaximumPasses=10 MinimumPasses=1 MinimumConvergedPasses=1 PercentRefinement=30 BasisOrder=1 PortAccuracy=2 DrivenSolverType="Direct Solver"
    sweep Sweep: 1.2GHz to 12GHz, 100 points; Type=Discrete SaveFields SaveRadFields
source amplitudes:
  1:1: 1V 0deg
radiation setups:
  Infinite Sphere1: Infinite Sphere Theta=-180deg..180deg step 2deg Phi=0deg..90deg step 90deg
reports:
  Terminal S Parameter Plot 5: dB(St(1,1)) vs Freq on Setup1 : Sweep
  Terminal S Parameter Plot 6: dB(St(1,1)) vs Freq on Setup1 : Sweep
  Terminal S Parameter Plot 7: dB(St(1,1)) vs Freq on Setup1 : Sweep
  Terminal S Parameter Plot 8: dB(St(1,1)) vs Freq on Setup1 : Sweep
  Terminal S Parameter Plot 9: dB(St(1,1)) vs Freq on Setup1 : Sweep
  Terminal S Parameter Plot 10: dB(St(1,1)) vs Freq on Setup1 : Sweep
  Terminal S Parameter Plot 4_1: dB(St(1,1)) vs Freq
  Terminal S Parameter Plot 11: dB(St(1,1)) vs Freq on Setup1 : Sweep
  Terminal S Parameter Plot 14: dB(St(1,1)) vs Freq on Setup1 : Sweep
  Terminal S Parameter Plot 15: dB(St(1,1)) vs Freq on Setup1 : Sweep
  Terminal S Parameter Plot 16: dB(St(1,1)) vs Freq on Setup1 : Sweep
  Terminal S Parameter Plot 17: dB(St(1,1)) vs Freq on Setup1 : Sweep
  Terminal S Parameter Plot 18: dB(St(1,1)) vs Freq on Setup2 : Sweep
  Terminal S Parameter Plot 19: dB(St(1,1)) vs Freq on Setup1 : Sweep
  Terminal S Parameter Plot 20: dB(St(1,1)) vs Freq on Setup1 : Sweep
  Terminal S Parameter Plot 22: dB(St(1,1)) vs Freq on Setup1 : Sweep
  Terminal S Parameter Plot 23: dB(St(1,1)) vs Freq on Setup2 : Sweep
  Terminal S Parameter Plot 24: dB(St(1,1)) vs Freq on Setup2 : Sweep
  Terminal S Parameter Plot 25: dB(St(1,1)) vs Freq on Setup1 : Sweep
  Terminal S Parameter Plot 26: dB(St(1,1)) vs Freq on Setup2 : Sweep
  Terminal S Parameter Plot 27: dB(St(1,1)) vs Freq on Setup1 : Sweep
  Terminal S Parameter Plot 28: dB(St(1,1)) vs Freq on Setup2 : Sweep
  Terminal S Parameter Plot 29: dB(St(1,1)) vs Freq on Setup1 : Sweep
  Terminal S Parameter Plot 30: dB(St(1,1)) vs Freq on Setup2 : Sweep
  Terminal S Parameter Plot 31: dB(St(1,1)) vs Freq on Setup3 : Sweep
  Terminal S Parameter Plot 32: dB(St(1,1)) vs Freq on Setup1 : Sweep
  Terminal S Parameter Plot 33: dB(St(1,1)) vs Freq on Setup1 : Sweep
  Terminal S Parameter Plot 34: dB(St(1,1)) vs Freq on Setup1 : Sweep
  Gain Plot 1: dB(GainTotal) vs Theta on Setup1 : LastAdaptive, Infinite Sphere1 [Phi=all Freq=2.4GHz]
  Terminal S Parameter Plot 35: dB(St(1,1)) vs Freq on Setup1 : Sweep
  Terminal S Parameter Plot 36: dB(St(1,1)) vs Freq on Setup1 : Sweep
